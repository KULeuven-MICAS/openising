// variable Vth inverter
simulator lang=spectre

//<START_LIBRARY>
// (I) I_pmos (S G D B) | pmos model
// (I) I_nmos (S G D B) | nmos model
// (P) P_supply         | supply of the circuit
// (P) P_nat_inv_vth    | native inverter threshold
//<END_LIBRARY>
include "$ANALOG_SETUP"

// subckt definition
subckt inv (in out vdd vss)
  parameters vth=0.5
  Vshift (gate in) vsource dc=(P_nat_inv_vth-vth)
  PMOS (out gate vdd vdd) I_pmos
  NMOS (out gate vss vss) I_nmos
ends inv
