// resistor couping unit
simulator lang=spectre

// subckt definition
subckt cu (L1 R1 L2 R2)
  parameters R=0

  swL (L1 Lp Lc) switch position=(R == 0) ? 0 : (R > 0) ? 1 : 2
  swR (R1 Rp Rc) switch position=(R == 0) ? 0 : (R > 0) ? 1 : 2

  Lp (Lp L2) resistor r=abs(R)
  Rp (Rp R2) resistor r=abs(R)
  Lc (Lc R2) resistor r=abs(R)
  Rc (Rc L2) resistor r=abs(R)
ends res_cu
